.lib /home/sumit/eda_tools/open_pdks/sky130/sky130A/libs.tech/ngspice/sky130.lib.spice tt

*--------------
.subckt not1 a vdd vss z
xm01 z a vdd vdd sky130_fd_pr__pfet_01v8 l=0.15 w=1.348 as=0.4044 ad=0.4044 ps=3.296 pd=3.296
xm02 z a vss vss sky130_fd_pr__nfet_01v8 l=0.15 w=0.42 as=0.126 ad=0.126 ps=1.44 pd=1.44
c3 a vss 0.385f
c2 z vss 0.576f
.ends

* The voltage source:
Vdd vdd gnd DC 1.8
Xnot1 in vdd gnd out not1

* dc analysis
V1 in 0 DC 0
.dc V1 0 1.8 0.01
.control
run
*plot V(in) V(out)
let slope=deriv(V(out))
*plot slope

meas dc VIL find v(in) when slope=-1 cross=1
meas dc VIH find v(in) when slope=-1 cross=2

let diff = V(in)-V(out)

meas dc VM find V(in) when diff=0

meas dc VOH max v(out)
meas dc VOL min v(out)

*--------------------------------
* Noise margins
*--------------------------------

let NMH = VOH - VIH
let NML = VIL - VOL

print NMH NML

.endc
.end
