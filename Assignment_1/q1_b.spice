.lib /home/sumit/eda_tools/open_pdks/sky130/sky130A/libs.tech/ngspice/sky130.lib.spice tt

* Deivce Parameters:
*--------------
*.subckt not1 a vdd vss z
*xm01 z a vdd vdd sky130_fd_pr__pfet_01v8 l=0.15 w=1.348 as=0.4044 ad=0.4044 ps=3.296 pd=3.296
*xm02 z a vss vss sky130_fd_pr__nfet_01v8 l=0.15 w=0.42 as=0.126 ad=0.126 ps=1.44 pd=1.44
*c3 a vss 0.385f
*c2 z vss 0.576f
*.ends

.subckt not1 A VDD GND Y
X0 Y A GND GND sky130_fd_pr__nfet_01v8 ad=0.189 pd=1.74 as=0.189 ps=1.74 w=0.42 l=0.15
X1 Y A VDD VDD sky130_fd_pr__pfet_01v8 ad=0.6075 pd=3.6 as=0.6075 ps=3.6 w=1.35 l=0.15
C0 A GND 0.03663f
C1 VDD GND 0.03283f
C2 A VDD 0.03795f
C3 VDD GND 0.00982f
C4 GND Y 0.04791f
C5 A VDD 0.05633f
C6 A Y 0.03034f
C7 VDD VDD 0.02784f
C8 VDD Y 0.07174f
C9 VDD Y 0.01038f
C10 GND GND 0.27643f
C11 Y GND 0.10081f
C12 VDD GND 0.2964f
C13 A GND 0.28039f
C14 VDD GND 0.29102f
.ends
* The voltage source:
*---------------------
Vdd vdd gnd DC 1.8
Xnot1 in vdd gnd out not1

Xnot2 out vdd gnd load not1

* dc analysis
*---------------------
V1 in 0 DC 0
.dc V1 0 1.8 0.01

*Plot and Parameters
*---------------------
.control
run
plot V(in) V(out)

let slope=deriv(V(out))
plot slope

meas dc VIL find v(in) when slope=-1 cross=1
meas dc VIH find v(in) when slope=-1 cross=2

let diff = V(in)-V(out)

meas dc VM find V(in) when diff=0

meas dc VOH max v(out)
meas dc VOL min v(out)

let NMH = VOH - VIH
let NML = VIL - VOL

print NMH NML

.endc
*---------------------

.end
