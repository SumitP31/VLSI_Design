* SPICE3 file created from INVX1.ext - technology: sky130A

X0 Y A VPWR VPWR sky130_fd_pr__pfet_01v8 ad=0.405 pd=3.3 as=0.405 ps=3.3 w=1.35 l=0.15
X1 Y A VGND VGND sky130_fd_pr__nfet_01v8 ad=0.126 pd=1.44 as=0.126 ps=1.44 w=0.42 l=0.15
X2 VPWR A Y VPWR sky130_fd_pr__pfet_01v8 ad=0.405 pd=3.3 as=0.405 ps=3.3 w=1.35 l=0.15
X3 VGND A Y VGND sky130_fd_pr__nfet_01v8 ad=0.126 pd=1.44 as=0.126 ps=1.44 w=0.42 l=0.15
C0 A Y 0.15021f
C1 VPWR Y 0.34447f
C2 A VPWR 0.16516f
C3 Y VGND 0.34994f
C4 A VGND 0.51422f
C5 VPWR VGND 1.32491f
