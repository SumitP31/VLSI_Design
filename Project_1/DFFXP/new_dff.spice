* NGSPICE file created from dff_layout.ext - technology: sky130A

.subckt dff_layout D CLK Q VDD VSS
X0 a_n510_10# CLK VDD VDD sky130_fd_pr__pfet_01v8 ad=0.4158 pd=3.18 as=0.378 ps=3.12 w=1.26 l=0.15
**devattr s=15120,624 d=16632,636
X1 Q a_5008_12# VSS VSS sky130_fd_pr__nfet_01v8 ad=0.126 pd=1.44 as=0.126 ps=1.44 w=0.42 l=0.15
**devattr s=5040,288 d=5040,288
X2 a_748_12# CLK a_658_12# VSS sky130_fd_pr__nfet_01v8 ad=0.126 pd=1.44 as=0.126 ps=1.44 w=0.42 l=0.15
**devattr s=5040,288 d=5040,288
X3 a_5008_12# a_3688_14# VSS VSS sky130_fd_pr__nfet_01v8 ad=0.126 pd=1.44 as=0.126 ps=1.44 w=0.42 l=0.15
**devattr s=5040,288 d=5040,288
X4 a_2068_10# a_748_12# VDD VDD sky130_fd_pr__pfet_01v8 ad=0.4032 pd=3.36 as=0.378 ps=3.12 w=1.26 l=0.15
**devattr s=15120,624 d=16632,636
X5 a_3598_14# a_5008_12# VSS VSS sky130_fd_pr__nfet_01v8 ad=0.126 pd=1.44 as=0.126 ps=1.44 w=0.42 l=0.15
**devattr s=5040,288 d=5040,288
X6 a_3688_14# a_n510_10# a_3598_14# VSS sky130_fd_pr__nfet_01v8 ad=0.126 pd=1.44 as=0.126 ps=1.44 w=0.42 l=0.15
**devattr s=5040,288 d=5040,288
X7 a_3688_14# CLK a_3598_14# VDD sky130_fd_pr__pfet_01v8 ad=0.2079 pd=1.92 as=0.2016 ps=1.68 w=0.63 l=0.15
**devattr s=7560,372 d=8316,384
X8 a_3598_14# a_5008_12# VDD VDD sky130_fd_pr__pfet_01v8 ad=0.4032 pd=3.36 as=0.378 ps=3.12 w=1.26 l=0.15
**devattr s=15120,624 d=16632,636
X9 a_3688_14# CLK a_2068_10# VSS sky130_fd_pr__nfet_01v8 ad=0.126 pd=1.44 as=0.126 ps=1.44 w=0.42 l=0.15
**devattr s=5040,288 d=5040,288
X10 a_n2_10# D VSS VSS sky130_fd_pr__nfet_01v8 ad=0.126 pd=1.44 as=0.126 ps=1.44 w=0.42 l=0.15
**devattr s=5040,288 d=5040,288
X11 a_5008_12# a_3688_14# VDD VDD sky130_fd_pr__pfet_01v8 ad=0.4158 pd=3.18 as=0.378 ps=3.12 w=1.26 l=0.15
**devattr s=15120,624 d=16632,636
X12 a_2068_10# a_748_12# VSS VSS sky130_fd_pr__nfet_01v8 ad=0.126 pd=1.44 as=0.126 ps=1.44 w=0.42 l=0.15
**devattr s=5040,288 d=5040,288
X13 a_658_12# a_2068_10# VSS VSS sky130_fd_pr__nfet_01v8 ad=0.126 pd=1.44 as=0.126 ps=1.44 w=0.42 l=0.15
**devattr s=5040,288 d=5040,288
X14 a_748_12# CLK a_n2_10# VDD sky130_fd_pr__pfet_01v8 ad=0.2079 pd=1.92 as=0.2016 ps=1.68 w=0.63 l=0.15
**devattr s=7560,372 d=8316,384
X15 a_n510_10# CLK VSS VSS sky130_fd_pr__nfet_01v8 ad=0.126 pd=1.44 as=0.126 ps=1.44 w=0.42 l=0.15
**devattr s=5040,288 d=5040,288
X16 a_748_12# a_n510_10# a_n2_10# VSS sky130_fd_pr__nfet_01v8 ad=0.126 pd=1.44 as=0.126 ps=1.44 w=0.42 l=0.15
**devattr s=5040,288 d=5040,288
X17 a_3688_14# a_n510_10# a_2068_10# VDD sky130_fd_pr__pfet_01v8 ad=0.2079 pd=1.92 as=0.2016 ps=1.68 w=0.63 l=0.15
**devattr s=7560,372 d=8316,384
X18 Q a_5008_12# VDD VDD sky130_fd_pr__pfet_01v8 ad=0.4158 pd=3.18 as=0.378 ps=3.12 w=1.26 l=0.15
**devattr s=15120,624 d=16632,636
X19 a_n2_10# D VDD VDD sky130_fd_pr__pfet_01v8 ad=0.4032 pd=3.36 as=0.378 ps=3.12 w=1.26 l=0.15
**devattr s=15120,624 d=16632,636
X20 a_748_12# a_n510_10# a_658_12# VDD sky130_fd_pr__pfet_01v8 ad=0.2079 pd=1.92 as=0.2016 ps=1.68 w=0.63 l=0.15
**devattr s=7560,372 d=8316,384
X21 a_658_12# a_2068_10# VDD VDD sky130_fd_pr__pfet_01v8 ad=0.4032 pd=3.36 as=0.378 ps=3.12 w=1.26 l=0.15
**devattr s=15120,624 d=16632,636
C0 a_3598_14# a_2068_10# 0.15261f
C1 a_n510_10# a_748_12# 0.41755f
C2 VDD D 0.14203f
C3 a_748_12# CLK 0.0842f
C4 VDD Q 0.14979f
C5 a_5008_12# a_3688_14# 0.05172f
C6 a_658_12# a_3688_14# 0
C7 a_658_12# a_n2_10# 0.12654f
C8 a_3598_14# a_3688_14# 0.5011f
C9 VDD a_n510_10# 2.3423f
C10 VDD CLK 3.21294f
C11 a_5008_12# Q 0.04316f
C12 a_658_12# D 0
C13 a_2068_10# a_3688_14# 0.43907f
C14 VDD a_748_12# 0.29586f
C15 a_2068_10# a_n2_10# 0.02396f
C16 a_3598_14# Q 0.00191f
C17 a_5008_12# a_n510_10# 0
C18 a_5008_12# CLK 0
C19 a_658_12# a_n510_10# 0.79553f
C20 a_658_12# CLK 0.46214f
C21 a_3598_14# a_n510_10# 0.10154f
C22 a_3598_14# CLK 0.26761f
C23 a_658_12# a_748_12# 0.46048f
C24 a_2068_10# a_n510_10# 0.49813f
C25 a_2068_10# CLK 0.42791f
C26 a_3598_14# a_748_12# 0
C27 a_n2_10# D 0.03913f
C28 a_2068_10# a_748_12# 0.05641f
C29 VDD a_5008_12# 1.03105f
C30 VDD a_658_12# 0.47334f
C31 a_n510_10# a_3688_14# 0.04141f
C32 a_3688_14# CLK 0.26179f
C33 VDD a_3598_14# 0.60574f
C34 a_n2_10# a_n510_10# 0.56858f
C35 a_n2_10# CLK 0.49457f
C36 VDD a_2068_10# 0.77511f
C37 a_n510_10# D 0.02094f
C38 D CLK 0.0767f
C39 a_n2_10# a_748_12# 0.43294f
C40 a_748_12# D 0
C41 a_5008_12# a_3598_14# 0.49308f
C42 a_658_12# a_3598_14# 0.00606f
C43 a_5008_12# a_2068_10# 0.00688f
C44 a_n510_10# CLK 1.29642f
C45 VDD a_3688_14# 0.32117f
C46 a_658_12# a_2068_10# 0.25097f
C47 VDD a_n2_10# 0.44903f
C48 Q VSS 1.05532f
C49 VDD VSS 12.5895f
C50 a_3598_14# VSS 2.76841f
C51 a_658_12# VSS 1.87346f
C52 a_n2_10# VSS 0.80099f
.ends
