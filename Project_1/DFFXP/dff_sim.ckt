.lib /home/sumit/eda_tools/open_pdks/sky130/sky130A/libs.tech/ngspice/sky130.lib.spice tt

.include "dff_layout.spice"

* The voltage source:
*--------------------------------------------------------
VDD vdd 0 DC 1.8

VIN1 CLK 0 PULSE(0 1.8 0 10p 10p 2n 4n)
*VIN3 CLKb 0 PULSE(0 1.8 0 10p 10p 1n 2n)
VIN2 D 0 PULSE(1.8 0 0 10p 10p 1n 3n)
.tran 1p 20n
*--------------------------------------------------------
*XINV3 D vdd 0 Db INVX1
*XINV2 CLK vdd 0 CLKb INVX1
XDFF1 D CLK vdd 0 out DFF
*XINV4 Y vdd 0 out INVX1
*XINV1 out load 0 vdd INVX1

Cload out 0 0.5f

*--------------------------------------------------------
.meas tran tr TRIG V(out) VAL=0.36 RISE=1 TARG V(out) VAL=1.44 RISE=1
.meas tran tf TRIG V(out) VAL=1.44 FALL=1 TARG V(out) VAL=0.36 FALL=1

*.meas tran tphl TRIG V(in1) VAL=0.9 RISE=1 TARG V(out) VAL=0.9 FALL=1
**.meas tran tplh TRIG V(in1) VAL=0.9 FALL=1 TARG V(out) VAL=0.9 RISE=1

* Power drawn from VDD.  The minus sign is required because SPICE reports
* current entering the positive terminal of VDD (a delivering source is negative).
* Measure 4 ns to 8 ns to exclude the initial transient; this is one full cycle.
*.meas tran pavg AVG par('-v(vdd)*i(VDD)') FROM=4n TO=8n
*.meas tran energy_per_cycle INTEG par('-v(vdd)*i(VDD)') FROM=4n TO=8n
*--------------------------------------------------------

.control
run

plot V(CLK) V(D) V(out)
*plot  V(in1) V(out)
*meas tran VM find V(out) when V(in1)=V(out) cross=-1
*print VM

.endc

.end
