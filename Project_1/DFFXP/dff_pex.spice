* NGSPICE file created from DFF.ext - technology: sky130A

.subckt MUX_2x1 D li_749_132# Qd CLK VPWR Qb VGND CLKb
X0 Qd CLK D VPWR sky130_fd_pr__pfet_01v8 ad=0.14175 pd=1.08 as=0.2835 ps=2.16 w=0.63 l=0.15
**devattr s=11340,432 d=5670,216
X1 Qd CLKb D VGND sky130_fd_pr__nfet_01v8 ad=0.0945 pd=0.87 as=0.189 ps=1.74 w=0.42 l=0.15
**devattr s=7560,348 d=3780,174
X2 Qb CLK Qd VGND sky130_fd_pr__nfet_01v8 ad=0.189 pd=1.74 as=0.0945 ps=0.87 w=0.42 l=0.15
**devattr s=3780,174 d=7560,348
X3 Qb CLKb Qd VPWR sky130_fd_pr__pfet_01v8 ad=0.2835 pd=2.16 as=0.14175 ps=1.08 w=0.63 l=0.15
**devattr s=5670,216 d=11340,432
C0 VPWR Qb 0.06085f
C1 CLKb Qb 0.04041f
C2 VPWR CLKb 0.32146f
C3 Qb CLK 0.01515f
C4 VPWR CLK 0.23971f
C5 CLKb CLK 0.04132f
C6 VPWR D 0.05559f
C7 D CLKb 0.00729f
C8 li_749_132# Qb 0
C9 D CLK 0.05214f
C10 Qd Qb 0.06309f
C11 VPWR li_749_132# 0
C12 li_749_132# CLKb 0.00103f
C13 VPWR Qd 0.03154f
C14 Qd CLKb 0.0206f
C15 Qd CLK 0.04511f
C16 Qd D 0.06309f
C17 li_749_132# VGND 0.02904f
C18 Qb VGND 0.08129f
C19 Qd VGND 0.49309f
C20 D VGND 0.53378f
C21 VPWR VGND 1.28818f
.ends

.subckt INVX1 A Y VGND VPWR
X0 Y A VPWR VPWR sky130_fd_pr__pfet_01v8 ad=0.378 pd=3.12 as=0.378 ps=3.12 w=1.26 l=0.15
**devattr s=15120,624 d=15120,624
X1 Y A VGND VGND sky130_fd_pr__nfet_01v8 ad=0.126 pd=1.44 as=0.126 ps=1.44 w=0.42 l=0.15
**devattr s=5040,288 d=5040,288
C0 VPWR Y 0.08514f
C1 VPWR A 0.11466f
C2 Y A 0.03397f
C3 Y VGND 0.34874f
C4 VPWR VGND 0.77358f
.ends

.subckt LATCH INVX1_0/A INVX1_1/VPWR INVX1_1/Y MUX_2x1_0/CLKb MUX_2x1_0/D INVX1_1/A
+ MUX_2x1_0/CLK VSUBS
XMUX_2x1_0 MUX_2x1_0/D INVX1_0/A INVX1_0/A MUX_2x1_0/CLK INVX1_1/VPWR INVX1_1/Y VSUBS
+ MUX_2x1_0/CLKb MUX_2x1
XINVX1_0 INVX1_0/A INVX1_1/A VSUBS INVX1_1/VPWR INVX1
XINVX1_1 INVX1_1/A INVX1_1/Y VSUBS INVX1_1/VPWR INVX1
C0 MUX_2x1_0/CLKb INVX1_1/Y 0.01825f
C1 INVX1_1/Y MUX_2x1_0/CLK 0
C2 MUX_2x1_0/D INVX1_1/Y 0.00156f
C3 INVX1_0/A INVX1_1/VPWR 0.04387f
C4 INVX1_1/A INVX1_1/Y 0.05095f
C5 MUX_2x1_0/D MUX_2x1_0/CLKb 0
C6 INVX1_1/A MUX_2x1_0/CLKb 0.00103f
C7 INVX1_0/A INVX1_1/Y 0.08838f
C8 INVX1_0/A MUX_2x1_0/CLKb 0.03556f
C9 INVX1_1/Y INVX1_1/VPWR 0.48525f
C10 MUX_2x1_0/CLKb INVX1_1/VPWR 0.06156f
C11 INVX1_0/A MUX_2x1_0/CLK 0.0102f
C12 INVX1_0/A MUX_2x1_0/D 0.00661f
C13 INVX1_0/A INVX1_1/A 0.00948f
C14 INVX1_1/VPWR MUX_2x1_0/CLK -0
C15 INVX1_1/A INVX1_1/VPWR 0.05301f
C16 INVX1_1/VPWR VSUBS -0.31695f
C17 INVX1_0/A VSUBS 0.05855f
C18 INVX1_1/A VSUBS -0.11921f
C19 INVX1_1/Y VSUBS 0.03439f
C20 MUX_2x1_0/D VSUBS -0
C21 MUX_2x1_0/CLKb VSUBS -0.00238f
C22 MUX_2x1_0/CLK VSUBS -0.00227f
.ends

.subckt DFF D CLK VPWR VGND Q
XLATCH_0 LATCH_0/INVX1_0/A VPWR LATCH_0/INVX1_1/Y CLKB INVX1_0/Y Q1 CLK VGND LATCH
XLATCH_1 LATCH_1/INVX1_0/A VPWR LATCH_1/INVX1_1/Y CLK Q1 INVX1_1/A CLKB VGND LATCH
XINVX1_0 D INVX1_0/Y VGND VPWR INVX1
XINVX1_1 INVX1_1/A Q VGND VPWR INVX1
XINVX1_2 CLK CLKB VGND VPWR INVX1
C0 LATCH_1/INVX1_1/Y LATCH_1/INVX1_0/A -0.00745f
C1 LATCH_0/INVX1_1/Y LATCH_1/INVX1_0/A 0
C2 CLKB Q1 0.42764f
C3 INVX1_1/A LATCH_1/INVX1_1/Y 0.09902f
C4 CLKB LATCH_1/INVX1_1/Y 0
C5 D LATCH_0/INVX1_0/A 0.00145f
C6 CLKB LATCH_0/INVX1_1/Y 0.10564f
C7 CLK Q 0
C8 CLKB INVX1_0/Y 0.0028f
C9 VPWR LATCH_0/INVX1_0/A -0.00932f
C10 D VPWR 0.00623f
C11 CLK Q1 0.11f
C12 CLK LATCH_1/INVX1_1/Y 0.03893f
C13 LATCH_0/INVX1_1/Y CLK 0.0591f
C14 Q LATCH_1/INVX1_1/Y 0.00169f
C15 CLK INVX1_0/Y 0.08023f
C16 Q1 LATCH_1/INVX1_1/Y 0.00144f
C17 VPWR LATCH_1/INVX1_0/A -0.00136f
C18 LATCH_0/INVX1_1/Y Q1 0.1362f
C19 LATCH_0/INVX1_0/A CLKB 0.05577f
C20 Q1 INVX1_0/Y 0
C21 VPWR INVX1_1/A 0.10753f
C22 D CLKB 0.00233f
C23 LATCH_0/INVX1_1/Y LATCH_1/INVX1_1/Y 0
C24 VPWR CLKB 0.21704f
C25 LATCH_0/INVX1_1/Y INVX1_0/Y 0.00439f
C26 INVX1_1/A LATCH_1/INVX1_0/A 0.00461f
C27 LATCH_0/INVX1_0/A CLK 0.18182f
C28 D CLK 0.00676f
C29 CLKB LATCH_1/INVX1_0/A 0
C30 VPWR CLK 0.20541f
C31 INVX1_1/A CLKB 0
C32 LATCH_0/INVX1_0/A Q1 0.00123f
C33 VPWR Q 0.00275f
C34 D Q1 0
C35 LATCH_0/INVX1_0/A LATCH_0/INVX1_1/Y -0.02501f
C36 VPWR Q1 0.31248f
C37 D LATCH_0/INVX1_1/Y 0
C38 LATCH_0/INVX1_0/A INVX1_0/Y 0.00651f
C39 CLK LATCH_1/INVX1_0/A 0.14831f
C40 D INVX1_0/Y 0.00176f
C41 INVX1_1/A CLK 0.00579f
C42 VPWR LATCH_1/INVX1_1/Y 0.04436f
C43 VPWR LATCH_0/INVX1_1/Y -0.03432f
C44 INVX1_1/A Q 0.00345f
C45 VPWR INVX1_0/Y 0.15187f
C46 CLKB CLK 0.24864f
C47 Q1 LATCH_1/INVX1_0/A 0.00464f
C48 INVX1_1/A Q1 0
C49 Q VGND 0.03782f
C50 D VGND 0.02381f
C51 LATCH_1/INVX1_0/A VGND -0.34932f
C52 INVX1_1/A VGND -0.13915f
C53 LATCH_1/INVX1_1/Y VGND -0.44009f
C54 VPWR VGND -1.66462f
C55 LATCH_0/INVX1_0/A VGND -0.35043f
C56 Q1 VGND -0.13776f
C57 LATCH_0/INVX1_1/Y VGND -0.45289f
C58 INVX1_0/Y VGND -0.05866f
C59 CLKB VGND 0.23821f
C60 CLK VGND 1.33178f
.ends
