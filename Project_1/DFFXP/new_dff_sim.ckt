*============================================================
* DFF SETUP TIME CHARACTERIZATION
* SKY130A
*============================================================

.lib /home/sumit/eda_tools/open_pdks/sky130/sky130A/libs.tech/ngspice/sky130.lib.spice tt

.include "dff_pex.spice"

*============================================================
* SUPPLY
*============================================================

VDD vdd 0 DC 1.8

*============================================================
* CLOCK
*
* Rising edges:
*   0 ns
*   4 ns
*   8 ns
*
* We characterize the rising edge at 4 ns.
*============================================================

VCLK CLK 0 PULSE(0 1.8 1n 1000p 1000p 1n 4n)

*============================================================
* SETUP TIME
*
* D changes at:
*
*       tD = 4 ns - TSETUP
*
* Change this value manually for now.
*============================================================

.param TSETUP=348p

VDATA D 0 PULSE(1.8 0 {5n-TSETUP} 1000p 1000p 1n 3n)

*============================================================
* DFF
*============================================================

XDFF1 D CLK vdd 0 out DFF

*============================================================
* OUTPUT LOAD
*============================================================

Cload out 0 0.5f

*============================================================
* TRANSIENT ANALYSIS
*============================================================

.tran 1p 8n

*============================================================
* OUTPUT RISE TIME
*
* 20% VDD = 0.36 V
* 80% VDD = 1.44 V
*============================================================

.meas tran tr TRIG V(out) VAL=0.36 RISE=1 TARG V(out) VAL=1.44 RISE=1

*============================================================
* OUTPUT FALL TIME
*============================================================

.meas tran tf TRIG V(out) VAL=1.44 FALL=1 TARG V(out) VAL=0.36 FALL=1

*============================================================
* OUTPUT VALUE AFTER ACTIVE CLOCK EDGE
*
* At 5 ns we check Q.
*============================================================

.meas tran Q_after_clk FIND V(out) AT=5n

*============================================================
* CLOCK-TO-Q
*
* For this test D goes HIGH -> LOW, so Q should eventually
* fall. Therefore measure falling output.
*============================================================

.meas tran clk_to_q TRIG V(CLK) VAL=0.9 RISE=1 TARG V(out) VAL=0.9 FALL=1

*============================================================
* POWER
*============================================================

.meas tran Pavg AVG par('-V(vdd)*I(VDD)') FROM=4n TO=8n

.meas tran Energy INTEG par('-V(vdd)*I(VDD)') FROM=4n TO=8n

*============================================================
* CONTROL
*============================================================

.control

run

plot V(CLK)+4 V(D)+2 V(out)

.endc

.end
