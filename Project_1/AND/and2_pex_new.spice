* NGSPICE file created from AND2.ext - technology: sky130A

.subckt AND2 A B VPWR VGND Y
X0 VGND x2 Y VGND sky130_fd_pr__nfet_01v8 ad=0.126 pd=1.29 as=0.126 ps=1.44 w=0.42 l=0.15
**devattr s=5040,288 d=5040,288
X1 VPWR x2 Y VPWR sky130_fd_pr__pfet_01v8 ad=0.378 pd=3.04228 as=0.378 ps=3.12 w=1.26 l=0.15
**devattr s=15120,624 d=15120,624
X2 x3 A VGND VGND sky130_fd_pr__nfet_01v8 ad=0.252 pd=2.28 as=0.252 ps=2.58 w=0.84 l=0.15
**devattr s=10080,456 d=10080,456
X3 x2 x1 x3 VGND sky130_fd_pr__nfet_01v8 ad=0.252 pd=2.28 as=0.252 ps=2.28 w=0.84 l=0.15
**devattr s=10080,456 d=10080,456
X4 VGND B x1 VGND sky130_fd_pr__nfet_01v8 ad=0.126 pd=1.29 as=0.126 ps=1.44 w=0.42 l=0.15
**devattr s=5040,288 d=5040,288
X5 VPWR B x1 VPWR sky130_fd_pr__pfet_01v8 ad=0.378 pd=3.04228 as=0.378 ps=3.12 w=1.26 l=0.15
**devattr s=15120,624 d=15120,624
X6 x2 A VPWR VPWR sky130_fd_pr__pfet_01v8 ad=0.4905 pd=3.87 as=0.4905 ps=3.94772 w=1.635 l=0.15
**devattr s=19620,774 d=19620,774
X7 VPWR x1 x2 VPWR sky130_fd_pr__pfet_01v8 ad=0.4905 pd=3.94772 as=0.4905 ps=3.87 w=1.635 l=0.15
**devattr s=19620,774 d=19620,774
C0 A VPWR 0.09635f
C1 x2 VPWR 0.39844f
C2 x3 VPWR 0.00333f
C3 x1 B 0.03505f
C4 x1 Y 0
C5 A x1 0.03287f
C6 x2 x1 0.0975f
C7 A B 0
C8 x1 x3 0.00705f
C9 x2 B 0
C10 x3 B 0
C11 A Y 0
C12 x2 Y 0.04092f
C13 x1 VPWR 0.32992f
C14 VPWR B 0.11637f
C15 Y VPWR 0.10833f
C16 x2 A 0.08446f
C17 A x3 0.00751f
C18 x2 x3 0.05745f
C19 Y VGND 0.53912f
C20 VPWR VGND 2.36446f
C21 x3 VGND 0.8f
C22 x2 VGND 0.4221f
.ends
