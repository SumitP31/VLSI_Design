.lib /home/sumit/eda_tools/open_pdks/sky130/sky130A/libs.tech/ngspice/sky130.lib.spice tt

* Deivce Parameters:
*--------------
.param PW= 9.25
.param AD = {PW*0.3}
.param AS={PW*0.3}
.param PS={2*(PW+0.3)}
.param PD={2*(PW+0.3)}

*------------Inveter for first input and load --------------
.subckt INVX1 A VPWR VGND Y
X0 Y A VPWR VPWR sky130_fd_pr__pfet_01v8 ad=0.405 pd=3.3 as=0.405 ps=3.3 w=1.35 l=0.15

X1 Y A VGND VGND sky130_fd_pr__nfet_01v8 ad=0.126 pd=1.44 as=0.126 ps=1.44 w=0.42 l=0.15

C0 VPWR Y 0.13766f
C1 VPWR A 0.10451f
C2 Y A 0.03664f
C3 Y VGND 0.40665f
C4 VPWR VGND 0.82521f
.ends

*-----------AND with one inverted input----------
.subckt AND2 A B VPWR VGND Y
X0 VPWR B x1 VPWR sky130_fd_pr__pfet_01v8 ad=0.405 pd=3.59503 as=0.405 ps=3.3 w=1.35 l=0.15
**devattr s=16200,660 d=16200,660
X1 x2 x1 x3 VGND sky130_fd_pr__nfet_01v8 ad=0.126 pd=1.44 as=0.126 ps=1.44 w=0.42 l=0.15
**devattr s=5040,288 d=5040,288
X2 VPWR x1 x2 VPWR sky130_fd_pr__pfet_01v8 ad=0.138 pd=1.22497 as=0.138 ps=1.52 w=0.46 l=0.15
**devattr s=5520,304 d=5520,304
X3 x2 A VPWR VPWR sky130_fd_pr__pfet_01v8 ad=0.138 pd=1.52 as=0.138 ps=1.22497 w=0.46 l=0.15
**devattr s=5520,304 d=5520,304
X4 x3 A VGND VGND sky130_fd_pr__nfet_01v8 ad=0.126 pd=1.44 as=0.126 ps=1.44 w=0.42 l=0.15
**devattr s=5040,288 d=5040,288
X5 VGND x2 Y VGND sky130_fd_pr__nfet_01v8 ad=0.126 pd=1.44 as=0.126 ps=1.44 w=0.42 l=0.15
**devattr s=5040,288 d=5040,288
X6 VGND B x1 VGND sky130_fd_pr__nfet_01v8 ad=0.126 pd=1.44 as=0.126 ps=1.44 w=0.42 l=0.15
**devattr s=5040,288 d=5040,288
X7 VPWR x2 Y VPWR sky130_fd_pr__pfet_01v8 ad=0.405 pd=3.59503 as=0.405 ps=3.3 w=1.35 l=0.15
**devattr s=16200,660 d=16200,660
C0 x2 VPWR 0.31075f
C1 B x2 0
C2 x1 x2 0.08321f
C3 Y x3 0
C4 A x3 0.00303f
C5 A Y 0.00249f
C6 x3 VPWR 0.00132f
C7 x1 x3 0.003f
C8 Y VPWR 0.10413f
C9 x1 Y 0
C10 A VPWR 0.20418f
C11 A B 0
C12 A x1 0.01541f
C13 x2 x3 0.03943f
C14 Y x2 0.03937f
C15 B VPWR 0.11272f
C16 x1 VPWR 0.32475f
C17 x1 B 0.03641f
C18 A x2 0.06112f
C19 Y VGND 0.53531f
C20 VPWR VGND 2.082f
C21 x3 VGND 0.27306f
.ends

* The voltage source:
*--------------------------------------------------------
VDD vdd 0 DC 1.8

VIN1 in1 0 PULSE(0 1.8 0 20p 20p 2n 4n)
VIN2 in2 0 PULSE(1.8 0 0 20p 20p 2n 4n)

.tran 1p 6n
*--------------------------------------------------------
*XINV1 in2 vdd 0 out1 INVX1
XAND1 in1 in2 vdd 0 out AND2
XINV2 out vdd 0 load INVX1
*Cload out 0 10f
*--------------------------------------------------------
.meas tran tr TRIG V(out) VAL=0.36 RISE=1 TARG V(out) VAL=1.44 RISE=1
.meas tran tf TRIG V(out) VAL=1.44 FALL=1 TARG V(out) VAL=0.36 FALL=1

.meas tran tphl TRIG V(in1) VAL=0.9 RISE=1 TARG V(out) VAL=0.9 FALL=1
.meas tran tplh TRIG V(in1) VAL=0.9 FALL=1 TARG V(out) VAL=0.9 RISE=1
*--------------------------------------------------------

.control
run

plot V(in1) V(in2) V(out)
*plot  V(in2) V(out)
meas tran VM find V(out) when V(in2)=V(out) cross=-1
print VM

.endc

.end
