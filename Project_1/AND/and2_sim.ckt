.lib /home/sumit/eda_tools/open_pdks/sky130/sky130A/libs.tech/ngspice/sky130.lib.spice tt
.include and2_pex.spice
.include invx1_pex.spice

* Deivce Parameters:
*--------------
.param PW= 9.25
.param AD = {PW*0.3}
.param AS={PW*0.3}
.param PS={2*(PW+0.3)}
.param PD={2*(PW+0.3)}

* The voltage source:
*--------------------------------------------------------
VDD vdd 0 DC 1.8

VIN1 in1 0 PULSE(0 1.8 0 200p 200p 1.8n 4n)

*VIN2 in2 0 PULSE(1.8 0 0 20p 20p 2n 4n)

.tran 1p 6n
*--------------------------------------------------------
*XINV1 in2 vdd 0 out1 INVX1
XAND1 in1 in2 vdd 0 out AND2
*XINV2 out vdd 0 load INVX1
Cload out 0 10f
*--------------------------------------------------------
.meas tran tr TRIG V(out) VAL=0.36 RISE=1 TARG V(out) VAL=1.44 RISE=1
.meas tran tf TRIG V(out) VAL=1.44 FALL=1 TARG V(out) VAL=0.36 FALL=1

.meas tran tphl TRIG V(in1) VAL=0.9 RISE=1 TARG V(out) VAL=0.9 FALL=1
.meas tran tplh TRIG V(in1) VAL=0.9 FALL=1 TARG V(out) VAL=0.9 RISE=1
*--------------------------------------------------------

.control
run

plot V(in1) V(in2) V(out)
*plot  V(in2) V(out)

.endc

.end
