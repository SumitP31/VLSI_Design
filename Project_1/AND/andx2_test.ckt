.lib /home/sumit/eda_tools/open_pdks/sky130/sky130A/libs.tech/ngspice/sky130.lib.spice tt

* Deivce Parameters:
*--------------
.param PW= 9.25
.param AD = {PW*0.3}
.param AS={PW*0.3}
.param PS={2*(PW+0.3)}
.param PD={2*(PW+0.3)}

*------------Inveter for first input and load --------------
.subckt INVX1 A VPWR VGND Y
X0 Y A VPWR VPWR sky130_fd_pr__pfet_01v8 ad=0.405 pd=3.3 as=0.405 ps=3.3 w=1.35 l=0.15

X1 Y A VGND VGND sky130_fd_pr__nfet_01v8 ad=0.126 pd=1.44 as=0.126 ps=1.44 w=0.42 l=0.15

C0 VPWR Y 0.13766f
C1 VPWR A 0.10451f
C2 Y A 0.03664f
C3 Y VGND 0.40665f
C4 VPWR VGND 0.82521f
.ends

*-----------AND with one inverted input----------
.subckt AND1 A B VPWR VGND Y
X0 Y x2 x1 VPWR sky130_fd_pr__pfet_01v8 ad=2.835 pd=19.5 as=2.835 ps=19.5 w=9.45 l=0.15
**devattr s=113400,3900 d=113400,3900
X1 Y A VGND VGND sky130_fd_pr__nfet_01v8 ad=0.126 pd=1.44 as=0.126 ps=1.44 w=0.42 l=0.15
**devattr s=5040,288 d=5040,288
X2 VPWR B x2 VPWR sky130_fd_pr__pfet_01v8 ad=0.405 pd=2.85 as=0.405 ps=3.3 w=1.35 l=0.15
**devattr s=16200,660 d=16200,660
X3 Y x2 VGND VGND sky130_fd_pr__nfet_01v8 ad=0.126 pd=1.44 as=0.126 ps=1.44 w=0.42 l=0.15
**devattr s=5040,288 d=5040,288
X4 VGND B x2 VGND sky130_fd_pr__nfet_01v8 ad=0.126 pd=1.44 as=0.126 ps=1.44 w=0.42 l=0.15
**devattr s=5040,288 d=5040,288
X5 x1 A VPWR VPWR sky130_fd_pr__pfet_01v8 ad=2.835 pd=19.5 as=2.835 ps=19.95 w=9.45 l=0.15
**devattr s=113400,3900 d=113400,3900
C0 x2 B 0.04077f
C1 Y B 0
C2 x2 A 0.00564f
C3 Y A 0.01917f
C4 B x1 0
C5 B VPWR 0.0984f
C6 x1 A 0.08424f
C7 VPWR A 0.19645f
C8 x2 Y 0.15157f
C9 x2 x1 0.08424f
C10 Y x1 0.41933f
C11 x2 VPWR 0.22574f
C12 Y VPWR 0.47388f
C13 x1 VPWR 0.85838f
C14 Y VGND 0.57099f
C15 VPWR VGND 5.96369f
C16 x1 VGND 0.20201f
.ends

* The voltage source:
*--------------------------------------------------------
VDD vdd 0 DC 1.8

VIN1 in1 0 PULSE(0 1.8 0 20p 20p 2n 4n)
VIN2 in2 0 PULSE(1.8 0 0 20p 20p 2n 4n)

.tran 1p 6n
*--------------------------------------------------------
*XINV1 in2 vdd 0 out1 INVX1
XAND1 in1 in2 vdd 0 out AND1
XINV2 out vdd 0 load INVX1

*--------------------------------------------------------
.meas tran tr TRIG V(out) VAL=0.18 RISE=1 TARG V(out) VAL=1.62 RISE=1
.meas tran tf TRIG V(out) VAL=1.62 FALL=1 TARG V(out) VAL=0.18 FALL=1

.meas tran tphl TRIG V(in1) VAL=0.9 RISE=1 TARG V(out) VAL=0.9 FALL=1
.meas tran tplh TRIG V(in1) VAL=0.9 FALL=1 TARG V(out) VAL=0.9 RISE=1
*--------------------------------------------------------

.control
run

plot V(in1) V(in2) V(out)
*plot  V(in2) V(out)
meas tran VM find V(out) when V(in2)=V(out) cross=-1
print VM

.endc

.end
