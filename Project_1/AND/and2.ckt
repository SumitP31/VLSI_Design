.lib /home/sumit/eda_tools/open_pdks/sky130/sky130A/libs.tech/ngspice/sky130.lib.spice tt

* Deivce Parameters:
*--------------
.param PW= 1.66
.param AD = {PW*0.3}
.param AS={PW*0.3}
.param PS={2*(PW+0.3)}
.param PD={2*(PW+0.3)}

.param PW1= 1.26
.param AD1 = {PW1*0.3}
.param AS1={PW1*0.3}
.param PS1={2*(PW1+0.3)}
.param PD1={2*(PW1+0.3)}

.param PWn= 0.84
.param ADn = {PWn*0.3}
.param ASn={PWn*0.3}
.param PSn={2*(PWn+0.3)}
.param PDn={2*(PWn+0.3)}

*------------Inveter for first input and load --------------
.subckt INVX1 A VPWR VGND Y
X0 Y A VPWR VPWR sky130_fd_pr__pfet_01v8 L=0.15 w={PW1} as={AS1} ad={AD1} ps={PS1} pd={PD1}
X1 Y A VGND VGND sky130_fd_pr__nfet_01v8 ad=0.126 pd=1.44 as=0.126 ps=1.44 w=0.42 l=0.15

C0 VPWR Y 0.13766f
C1 VPWR A 0.10451f
C2 Y A 0.03664f
C3 Y VGND 0.40665f
C4 VPWR VGND 0.82521f
.ends

*-----------AND with one inverted input----------
.subckt AND2 A B VPWR VGND Y
*X2 VPWR B B2 VPWR sky130_fd_pr__pfet_01v8 L=0.15 w={PW1} as={AS1} ad={AD1} ps={PS1} pd={PD1}
*X6 B2 B VGND VGND sky130_fd_pr__nfet_01v8 ad=0.126 pd=1.44 as=0.126 ps=1.44 w=0.42 l=0.15

X0 Y A VPWR VPWR sky130_fd_pr__pfet_01v8 L=0.15 w={PW} as={AS} ad={AD} ps={PS} pd={PD}
X1 Y B VPWR VPWR sky130_fd_pr__pfet_01v8 L=0.15 w={PW} as={AS} ad={AD} ps={PS} pd={PD}

X4 Y B V1 VGND sky130_fd_pr__nfet_01v8 L=0.15 w={PWn} as={ASn} ad={ADn} ps={PSn} pd={PDn}
X5 V1 A VGND VGND sky130_fd_pr__nfet_01v8 L=0.15 w={PWn} as={ASn} ad={ADn} ps={PSn} pd={PDn}

*X3 Y B1 VPWR VPWR sky130_fd_pr__pfet_01v8 L=0.15 w={PW1} as={AS1} ad={AD1} ps={PS1} pd={PD1}
*X7 Y B1 VGND VGND sky130_fd_pr__nfet_01v8 ad=0.126 pd=1.44 as=0.126 ps=1.44 w=0.42 l=0.15

.ends

* The voltage source:
*--------------------------------------------------------
VDD vdd 0 DC 1.8

VIN1 in1 0 PULSE(1.8 0 0 10p 10p 1n 4n)
VIN2 in2 0 DC 0

.tran 1p 8n
*--------------------------------------------------------
XINV1 in2 vdd 0 in2b INVX1
XAND1 in1 in2b vdd 0 Y AND2
XINV2 Y vdd 0 out INVX1
XINV3 out vdd 0 load INVX1
*Cload out 0 0.5f

*--------------------------------------------------------
.meas tran tr TRIG V(out) VAL=0.36 RISE=1 TARG V(out) VAL=1.44 RISE=1
.meas tran tf TRIG V(out) VAL=1.44 FALL=1 TARG V(out) VAL=0.36 FALL=1

.meas tran tphl TRIG V(in1) VAL=0.9 RISE=1 TARG V(out) VAL=0.9 FALL=1
.meas tran tplh TRIG V(in1) VAL=0.9 FALL=1 TARG V(out) VAL=0.9 RISE=1

* Power drawn from VDD.  The minus sign is required because SPICE reports
* current entering the positive terminal of VDD (a delivering source is negative).
* Measure 4 ns to 8 ns to exclude the initial transient; this is one full cycle.
.meas tran pavg AVG par('-v(vdd)*i(VDD)') FROM=4n TO=8n
.meas tran energy_per_cycle INTEG par('-v(vdd)*i(VDD)') FROM=4n TO=8n
*--------------------------------------------------------

.control
run

*plot V(in1) V(in2)
*plot  V(in1) V(out)
*meas tran VM find V(out) when V(in1)=V(out) cross=-1
*print VM

.endc

.end
