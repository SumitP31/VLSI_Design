* NGSPICE file created from AND2.ext - technology: sky130A

.subckt AND2 A B VPWR VGND Y
X0 VPWR B x1 VPWR sky130_fd_pr__pfet_01v8 ad=0.405 pd=3.59503 as=0.405 ps=3.3 w=1.35 l=0.15
**devattr s=16200,660 d=16200,660
X1 x2 x1 x3 VGND sky130_fd_pr__nfet_01v8 ad=0.126 pd=1.44 as=0.126 ps=1.44 w=0.42 l=0.15
**devattr s=5040,288 d=5040,288
X2 VPWR x1 x2 VPWR sky130_fd_pr__pfet_01v8 ad=0.138 pd=1.22497 as=0.138 ps=1.52 w=0.46 l=0.15
**devattr s=5520,304 d=5520,304
X3 x2 A VPWR VPWR sky130_fd_pr__pfet_01v8 ad=0.138 pd=1.52 as=0.138 ps=1.22497 w=0.46 l=0.15
**devattr s=5520,304 d=5520,304
X4 x3 A VGND VGND sky130_fd_pr__nfet_01v8 ad=0.126 pd=1.44 as=0.126 ps=1.44 w=0.42 l=0.15
**devattr s=5040,288 d=5040,288
X5 VGND x2 Y VGND sky130_fd_pr__nfet_01v8 ad=0.126 pd=1.44 as=0.126 ps=1.44 w=0.42 l=0.15
**devattr s=5040,288 d=5040,288
X6 VGND B x1 VGND sky130_fd_pr__nfet_01v8 ad=0.126 pd=1.44 as=0.126 ps=1.44 w=0.42 l=0.15
**devattr s=5040,288 d=5040,288
X7 VPWR x2 Y VPWR sky130_fd_pr__pfet_01v8 ad=0.405 pd=3.59503 as=0.405 ps=3.3 w=1.35 l=0.15
**devattr s=16200,660 d=16200,660
C0 x2 VPWR 0.31075f
C1 B x2 0
C2 x1 x2 0.08321f
C3 Y x3 0
C4 A x3 0.00303f
C5 A Y 0.00249f
C6 x3 VPWR 0.00132f
C7 x1 x3 0.003f
C8 Y VPWR 0.10413f
C9 x1 Y 0
C10 A VPWR 0.20418f
C11 A B 0
C12 A x1 0.01541f
C13 x2 x3 0.03943f
C14 Y x2 0.03937f
C15 B VPWR 0.11272f
C16 x1 VPWR 0.32475f
C17 x1 B 0.03641f
C18 A x2 0.06112f
C19 Y VGND 0.53531f
C20 VPWR VGND 2.082f
C21 x3 VGND 0.27306f
.ends
