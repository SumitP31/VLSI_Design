* NGSPICE file created from AND2.ext - technology: sky130A

.subckt AND2 A B VPWR VGND Y
X0 VGND x2 Y VGND sky130_fd_pr__nfet_01v8 ad=0.126 pd=1.44 as=0.126 ps=1.44 w=0.42 l=0.15
**devattr s=5040,288 d=5040,288
X1 x3 A VGND VGND sky130_fd_pr__nfet_01v8 ad=0.126 pd=1.44 as=0.126 ps=1.44 w=0.42 l=0.15
**devattr s=5040,288 d=5040,288
X2 x2 x1 x3 VGND sky130_fd_pr__nfet_01v8 ad=0.126 pd=1.44 as=0.126 ps=1.44 w=0.42 l=0.15
**devattr s=5040,288 d=5040,288
X3 VGND B x1 VGND sky130_fd_pr__nfet_01v8 ad=0.126 pd=1.44 as=0.126 ps=1.44 w=0.42 l=0.15
**devattr s=5040,288 d=5040,288
X4 VPWR x1 x2 VPWR sky130_fd_pr__pfet_01v8 ad=0.138 pd=1.22497 as=0.138 ps=1.52 w=0.46 l=0.15
**devattr s=5520,304 d=5520,304
X5 x2 A VPWR VPWR sky130_fd_pr__pfet_01v8 ad=0.138 pd=1.52 as=0.138 ps=1.22497 w=0.46 l=0.15
**devattr s=5520,304 d=5520,304
X6 VPWR x2 Y VPWR sky130_fd_pr__pfet_01v8 ad=0.405 pd=3.59503 as=0.405 ps=3.3 w=1.35 l=0.15
**devattr s=16200,660 d=16200,660
X7 VPWR B x1 VPWR sky130_fd_pr__pfet_01v8 ad=0.405 pd=3.59503 as=0.405 ps=3.3 w=1.35 l=0.15
**devattr s=16200,660 d=16200,660
C0 B VPWR 0.11316f
C1 x1 A 0.01541f
C2 Y x3 0
C3 x1 x2 0.08154f
C4 x2 A 0.0583f
C5 x1 Y 0
C6 x1 B 0.03641f
C7 VPWR x3 0.00134f
C8 A Y 0.00193f
C9 A B 0
C10 x2 Y 0.04063f
C11 x2 B 0
C12 x1 VPWR 0.3268f
C13 A VPWR 0.20967f
C14 x1 x3 0.003f
C15 x2 VPWR 0.29488f
C16 A x3 0.00303f
C17 x2 x3 0.04503f
C18 VPWR Y 0.1079f
C19 Y VGND 0.54275f
C20 VPWR VGND 2.13745f
C21 x3 VGND 0.24759f
.ends
