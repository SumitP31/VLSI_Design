* NGSPICE file created from AND2.ext - technology: sky130A

.subckt AND2 A B VPWR VGND Y
X0 VPWR x2 Y VPWR sky130_fd_pr__pfet_01v8 ad=0.378 pd=3.03781 as=0.378 ps=3.12 w=1.26 l=0.15
**devattr s=15120,624 d=15120,624
X1 VPWR x1 x2 VPWR sky130_fd_pr__pfet_01v8 ad=0.498 pd=4.00219 as=0.498 ps=3.92 w=1.66 l=0.15
**devattr s=19920,784 d=19920,784
X2 x2 x1 x3 VGND sky130_fd_pr__nfet_01v8 ad=0.252 pd=2.28 as=0.252 ps=2.28 w=0.84 l=0.15
**devattr s=10080,456 d=10080,456
X3 VGND x2 Y VGND sky130_fd_pr__nfet_01v8 ad=0.126 pd=1.29 as=0.126 ps=1.44 w=0.42 l=0.15
**devattr s=5040,288 d=5040,288
X4 x2 A VPWR VPWR sky130_fd_pr__pfet_01v8 ad=0.498 pd=3.92 as=0.498 ps=4.00219 w=1.66 l=0.15
**devattr s=19920,784 d=19920,784
X5 x3 A VGND VGND sky130_fd_pr__nfet_01v8 ad=0.252 pd=2.28 as=0.252 ps=2.58 w=0.84 l=0.15
**devattr s=10080,456 d=10080,456
X6 VPWR B x1 VPWR sky130_fd_pr__pfet_01v8 ad=0.378 pd=3.03781 as=0.378 ps=3.12 w=1.26 l=0.15
**devattr s=15120,624 d=15120,624
X7 VGND B x1 VGND sky130_fd_pr__nfet_01v8 ad=0.126 pd=1.29 as=0.126 ps=1.44 w=0.42 l=0.15
**devattr s=5040,288 d=5040,288
.ends
