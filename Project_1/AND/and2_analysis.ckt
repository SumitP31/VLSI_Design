AND2 PEX input-capacitance characterization
* Capacitance = charge delivered/absorbed by an input source divided by VDD.
* Each input is toggled with the other input held at its sensitizing value:
* B=0 for A, and A=1.8 V for B.  Outputs are unloaded except for PEX parasitics.

.lib /home/sumit/eda_tools/open_pdks/sky130/sky130A/libs.tech/ngspice/sky130.lib.spice tt
.include and2_pex.spice
.include invx1_pex.spice

.param Cl = 10e-15
.param SR = 200e-12

VDD vdd 0 1.8

VIN1 in1 0 PULSE(1.8 0 0 {SR} {SR} 1.8n 4n)
VIN2 in2 0 DC 0

* One rising and one falling edge per independent cell instance.
XAND1 in1 in2 vdd 0 out AND2
XINV1 out 0 VDD 0 INVX1
*Cload out 0 {Cl}

.tran 1p 8n

*.meas tran pavg AVG par('-v(vdd)*i(VDD)') FROM=4n TO=8n
*.meas tran energy_per_cycle INTEG par('-v(vdd)*i(VDD)') FROM=4n TO=8n

* Rising sources deliver negative SPICE branch current; falling sources absorb
* positive current.  The 200 ps windows include the complete input/output response.
.meas tran q_a_rise INTEG par('-i(VIN1)') FROM=2n TO= '2n+SR'
.meas tran q_a_fall INTEG par('i(VIN1)')  FROM=4n TO= '4n+SR'
*.meas tran q_b_rise INTEG par('-i(VIN1)') FROM=5n TO=5.2n
*.meas tran q_b_fall INTEG par('i(VIN1)')  FROM=7n TO=7.2n

.meas tran a_rise_cap PARAM='q_a_rise/1.8'
.meas tran a_fall_cap PARAM='q_a_fall/1.8'
.meas tran a_average_cap PARAM='(a_rise_cap+a_fall_cap)/2'
*.meas tran b_rise_cap PARAM='q_b_rise/1.8'
*.meas tran b_fall_cap PARAM='q_b_fall/1.8'
*.meas tran b_average_cap PARAM='(b_rise_cap+b_fall_cap)/2'

.control
run
plot V(in1) V(in2)
plot  V(in1) V(out)
print q_a_rise q_a_fall a_rise_cap a_fall_cap a_average_cap
*print q_b_rise q_b_fall b_rise_cap b_fall_cap b_average_cap
.endc

.end
