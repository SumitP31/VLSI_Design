.lib /home/sumit/eda_tools/open_pdks/sky130/sky130A/libs.tech/ngspice/sky130.lib.spice tt

.include "dff_pex_a.spice"

.subckt INVX1 A VPWR VGND Y
X0 Y A VPWR VPWR sky130_fd_pr__pfet_01v8 ad=0.378 pd=3.12 as=0.378 ps=3.12 w=1.26 l=0.15
X1 Y A VGND VGND sky130_fd_pr__nfet_01v8 ad=0.126 pd=1.44 as=0.126 ps=1.44 w=0.42 l=0.15

.ends

* The voltage source:
*--------------------------------------------------------
VDD vdd 0 DC 1.8

VIN1 CLK 0 PULSE(0 1.8 0 10p 10p 2n 4n)
*VIN3 CLKb 0 PULSE(0 1.8 0 10p 10p 1n 2n)
VIN2 D 0 PULSE(1.8 0 0 10p 10p 1n 3n)
.tran 1p 20n
*--------------------------------------------------------
XDFF1 D CLK out vdd 0 final_posdff_layout

*XINV1 out vdd 0 load INVX1

Cload out 0 0.5f

*--------------------------------------------------------
.meas tran tr TRIG V(out) VAL=0.36 RISE=1 TARG V(out) VAL=1.44 RISE=1
.meas tran tf TRIG V(out) VAL=1.44 FALL=1 TARG V(out) VAL=0.36 FALL=1

*.meas tran tphl TRIG V(in1) VAL=0.9 RISE=1 TARG V(out) VAL=0.9 FALL=1
**.meas tran tplh TRIG V(in1) VAL=0.9 FALL=1 TARG V(out) VAL=0.9 RISE=1

* Power drawn from VDD.  The minus sign is required because SPICE reports
* current entering the positive terminal of VDD (a delivering source is negative).
* Measure 4 ns to 8 ns to exclude the initial transient; this is one full cycle.
*.meas tran pavg AVG par('-v(vdd)*i(VDD)') FROM=4n TO=8n
*.meas tran energy_per_cycle INTEG par('-v(vdd)*i(VDD)') FROM=4n TO=8n
*--------------------------------------------------------

.control
run

plot V(CLK) V(D) V(out)
*plot  V(in1) V(out)
*meas tran VM find V(out) when V(in1)=V(out) cross=-1
*print VM

.endc

.end
