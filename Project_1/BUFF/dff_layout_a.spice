* NGSPICE file created from final_posdff_layout.ext - technology: sky130A

.subckt final_posdff_layout D CLK Q VDD VSS
X0 a_n510_10# CLK VDD VDD sky130_fd_pr__pfet_01v8 ad=0.4158 pd=3.18 as=0.378 ps=3.12 w=1.26 l=0.15
**devattr s=15120,624 d=16632,636
X1 Q a_5008_12# VSS VSS sky130_fd_pr__nfet_01v8 ad=0.126 pd=1.44 as=0.126 ps=1.44 w=0.42 l=0.15
**devattr s=5040,288 d=5040,288
X2 a_748_12# CLK a_658_12# VSS sky130_fd_pr__nfet_01v8 ad=0.126 pd=1.44 as=0.126 ps=1.44 w=0.42 l=0.15
**devattr s=5040,288 d=5040,288
X3 a_5008_12# a_3688_14# VSS VSS sky130_fd_pr__nfet_01v8 ad=0.126 pd=1.44 as=0.126 ps=1.44 w=0.42 l=0.15
**devattr s=5040,288 d=5040,288
X4 a_2068_10# a_748_12# VDD VDD sky130_fd_pr__pfet_01v8 ad=0.4032 pd=3.36 as=0.378 ps=3.12 w=1.26 l=0.15
**devattr s=15120,624 d=16632,636
X5 a_3598_14# a_5008_12# VSS VSS sky130_fd_pr__nfet_01v8 ad=0.126 pd=1.44 as=0.126 ps=1.44 w=0.42 l=0.15
**devattr s=5040,288 d=5040,288
X6 a_3688_14# a_n510_10# a_3598_14# VSS sky130_fd_pr__nfet_01v8 ad=0.126 pd=1.44 as=0.126 ps=1.44 w=0.42 l=0.15
**devattr s=5040,288 d=5040,288
X7 a_3688_14# CLK a_3598_14# VDD sky130_fd_pr__pfet_01v8 ad=0.2079 pd=1.92 as=0.2016 ps=1.68 w=0.63 l=0.15
**devattr s=7560,372 d=8316,384
X8 a_3598_14# a_5008_12# VDD VDD sky130_fd_pr__pfet_01v8 ad=0.4032 pd=3.36 as=0.378 ps=3.12 w=1.26 l=0.15
**devattr s=15120,624 d=16632,636
X9 a_3688_14# CLK a_2068_10# VSS sky130_fd_pr__nfet_01v8 ad=0.126 pd=1.44 as=0.126 ps=1.44 w=0.42 l=0.15
**devattr s=5040,288 d=5040,288
X10 a_n2_10# D VSS VSS sky130_fd_pr__nfet_01v8 ad=0.126 pd=1.44 as=0.126 ps=1.44 w=0.42 l=0.15
**devattr s=5040,288 d=5040,288
X11 a_5008_12# a_3688_14# VDD VDD sky130_fd_pr__pfet_01v8 ad=0.4158 pd=3.18 as=0.378 ps=3.12 w=1.26 l=0.15
**devattr s=15120,624 d=16632,636
X12 a_2068_10# a_748_12# VSS VSS sky130_fd_pr__nfet_01v8 ad=0.126 pd=1.44 as=0.126 ps=1.44 w=0.42 l=0.15
**devattr s=5040,288 d=5040,288
X13 a_658_12# a_2068_10# VSS VSS sky130_fd_pr__nfet_01v8 ad=0.126 pd=1.44 as=0.126 ps=1.44 w=0.42 l=0.15
**devattr s=5040,288 d=5040,288
X14 a_748_12# CLK a_n2_10# VDD sky130_fd_pr__pfet_01v8 ad=0.2079 pd=1.92 as=0.2016 ps=1.68 w=0.63 l=0.15
**devattr s=7560,372 d=8316,384
X15 a_n510_10# CLK VSS VSS sky130_fd_pr__nfet_01v8 ad=0.126 pd=1.44 as=0.126 ps=1.44 w=0.42 l=0.15
**devattr s=5040,288 d=5040,288
X16 a_748_12# a_n510_10# a_n2_10# VSS sky130_fd_pr__nfet_01v8 ad=0.126 pd=1.44 as=0.126 ps=1.44 w=0.42 l=0.15
**devattr s=5040,288 d=5040,288
X17 a_3688_14# a_n510_10# a_2068_10# VDD sky130_fd_pr__pfet_01v8 ad=0.2079 pd=1.92 as=0.2016 ps=1.68 w=0.63 l=0.15
**devattr s=7560,372 d=8316,384
X18 Q a_5008_12# VDD VDD sky130_fd_pr__pfet_01v8 ad=0.4158 pd=3.18 as=0.378 ps=3.12 w=1.26 l=0.15
**devattr s=15120,624 d=16632,636
X19 a_n2_10# D VDD VDD sky130_fd_pr__pfet_01v8 ad=0.4032 pd=3.36 as=0.378 ps=3.12 w=1.26 l=0.15
**devattr s=15120,624 d=16632,636
X20 a_748_12# a_n510_10# a_658_12# VDD sky130_fd_pr__pfet_01v8 ad=0.2079 pd=1.92 as=0.2016 ps=1.68 w=0.63 l=0.15
**devattr s=7560,372 d=8316,384
X21 a_658_12# a_2068_10# VDD VDD sky130_fd_pr__pfet_01v8 ad=0.4032 pd=3.36 as=0.378 ps=3.12 w=1.26 l=0.15
**devattr s=15120,624 d=16632,636
.ends
