* Post-layout extracted netlist for CharLib characterization.
* Pin order: A Y VGND VPWR
*.lib /foss/pdks/sky130A/libs.tech/ngspice/sky130.lib.spice tt
.subckt INVX1 A Y VGND VPWR
X0 Y A VPWR VPWR sky130_fd_pr__pfet_01v8 ad=0.405 pd=3.3 as=0.405 ps=3.3 w=1.35 l=0.15
X1 Y A VGND VGND sky130_fd_pr__nfet_01v8 ad=0.126 pd=1.44 as=0.126 ps=1.44 w=0.42 l=0.15
C0 VPWR Y 0.13766f
C1 VPWR A 0.10451f
C2 Y A 0.03664f
C3 Y VGND 0.40665f
C4 VPWR VGND 0.82521f
.ends INVX1
