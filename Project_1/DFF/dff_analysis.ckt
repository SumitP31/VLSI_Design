.lib /home/sumit/eda_tools/open_pdks/sky130/sky130A/libs.tech/ngspice/sky130.lib.spice tt

.include "dff_pex.spice"

.param SR = 10e-12
.param Cl = 0.5e-15

.param TR = 5e-9 - SR

* The voltage source:
*--------------------------------------------------------
VDD vdd 0 DC 1.8

VIN1 in2 0 PULSE(0 1.8 0 10p 10p 2n 4n)
VIN2 in1 0 PULSE(1.8 0 0 {SR} {SR} {TR} 10n)
.tran 1p 10n
*--------------------------------------------------------

XDFF1 in1 in2 vdd 0 out DFF

*XINV1 out load 0 vdd INVX1

Cload out 0 {Cl}

.tran 1p 8n

.control
* 3 x 3 characterization matrix:
*   Cl = 0.5 fF, 10 fF, 100 fF
*   SR = 10 ps, 100 ps, 1000 ps
foreach cl 0.5f 10f 100f
  foreach sr 10p 100p 1000p
    alterparam Cl = $cl
    alterparam SR = $sr
    reset
    run
    meas tran tr TRIG V(out) VAL=0.36 RISE=1 TARG V(out) VAL=1.44 RISE=1
    meas tran tf TRIG V(out) VAL=1.44 FALL=1 TARG V(out) VAL=0.36 FALL=1

    let tf = tf
    let tr = tr

    meas tran tphl TRIG V(in2) VAL=0.9 RISE=1 TARG V(out) VAL=0.9 FALL=1
    meas tran tplh TRIG V(in2) VAL=0.9 RISE=1 TARG V(out) VAL=0.9 RISE=1

    *plot V(in1) V(in2) V(out)
    *plot  V(in1) V(out)
    *plot I(vdd)
    print tr tf tphl tplh
    *print q_b_rise q_b_fall
    *---------------------------DYNAMIC POWER------------------------------
    let p_inst = -v(vdd) * i(VDD)

    meas tran tr_start WHEN v(in2)=0.36 RISE=1
    meas tran tr_end   WHEN v(out)=1.44 RISE=1

    meas tran rise_energy INTEG p_inst FROM=tr_start TO=tr_end
    let delta_tr = tr_end - tr_start
    let p_dynamic_rise = rise_energy / delta_tr

    print tr_start tr_end
    print rise_energy
    print p_dynamic_rise
    print '------------------------------------------------------------------'

    meas tran tf_start WHEN v(in2)=0.36 RISE=1
    meas tran tf_end   WHEN v(out)=0.36 FALL=1

    meas tran fall_energy INTEG p_inst FROM=tf_start TO=tf_end
    let delta_tf = tf_end - tf_start
    let p_dynamic_fall = fall_energy / delta_tf

    print tf_start tf_end
    print fall_energy
    print p_dynamic_fall

    echo "========================================" >> simulation_results.txt
    echo "Parameters_Slew_ps = $sr" >> simulation_results.txt
    echo "Parameters_CL_fF = $cl" >> simulation_results.txt

    echo "Rise_time = $&tr" >> simulation_results.txt
    echo "Fall_time = $&tf" >> simulation_results.txt

    echo "PHL_time = $&tphl" >> simulation_results.txt
    echo "PLH_time = $&tplh" >> simulation_results.txt

    echo "p_dynamic_rise = $&p_dynamic_rise" >> simulation_results.txt
    echo "p_dynamic_fall = $&p_dynamic_fall" >> simulation_results.txt
    echo "========================================" >> simulation_results.txt
  end
end

.endc

.end
